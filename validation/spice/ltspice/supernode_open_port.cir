* CircuitScope DC operating point
* Format: ltspice; configuration: full drawing
* Probes add no electrical branch. All source values are SI numbers.
* Node 0 = '0'
* Node n1 = 'Va'
* Node n2 = 'Vb'
* This exports an operating point, not a schematic or a physical op-amp model. Supplies are implicit; no timing, bias, current limit or real-chip behavior is modeled.
V_V1 n1 n2 6
R_R1 n1 0 1000
R_R2 n2 0 2000
.options reltol=1e-8 abstol=1e-12 vntol=1e-10
.save all
.op
.end
