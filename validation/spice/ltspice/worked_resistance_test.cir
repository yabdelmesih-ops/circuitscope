* CircuitScope DC operating point
* Format: ltspice; configuration: full drawing
* Probes add no electrical branch. All source values are SI numbers.
* Node 0 = '0'
* Node n1 = 'Va'
* Node n2 = 'Vb'
* This exports an operating point, not a schematic or a physical op-amp model. Supplies are implicit; no timing, bias, current limit or real-chip behavior is modeled.
V_V1 n2 0 0
R_R1 n2 n1 1000
R_R3 n1 n2 2000
I_Itest 0 n1 1
.options reltol=1e-8 abstol=1e-12 vntol=1e-10
.save all
.op
.end
