* CircuitScope DC operating point
* Format: ngspice; configuration: full drawing
* Probes add no electrical branch. All source values are SI numbers.
* Node 0 = '0'
* Node n1 = 'Va'
* This exports an operating point, not a schematic or a physical op-amp model. Supplies are implicit; no timing, bias, current limit or real-chip behavior is modeled.
I_I1 0 n1 0.0030000000000000001
R_R1 n1 0 2000
.options reltol=1e-8 abstol=1e-12 vntol=1e-10
.save all
.op
.end
