* CircuitScope DC operating point
* Format: ngspice; configuration: full drawing
* Probes add no electrical branch. All source values are SI numbers.
* Node 0 = '0'
* Node n1 = 'Vin'
* Node n2 = 'Vout'
* Node n3 = 'Vref'
* Comparators use ideal two-level behavioral sources. Threshold ambiguity is checked before export; the raw SPICE expression chooses LOW at equality and has no 1 nV guard. Recheck inputs after editing the file.
* This exports an operating point, not a schematic or a physical op-amp model. Supplies are implicit; no timing, bias, current limit or real-chip behavior is modeled.
V_V1 n1 0 3
V_V2 n3 0 2
B_U1 n2 0 V=(V(n1)-V(n3))>0 ? 5 : 0
R_RL n2 0 1000
.options reltol=1e-8 abstol=1e-12 vntol=1e-10
.save all
.op
.end
